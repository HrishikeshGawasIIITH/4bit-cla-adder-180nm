* SPICE3 file created from dff.ext - technology: scmos

.option scale=0.09u

M1000 out a_64_49# vdd inverter_0/w_0_n60# CMOSP w=40 l=2
+  ad=200 pd=90 as=800 ps=360
M1001 out a_64_49# gnd Gnd CMOSN w=20 l=2
+  ad=100 pd=50 as=400 ps=200
M1002 gnd clk a_40_9# Gnd CMOSN w=20 l=2
+  ad=0 pd=0 as=120 ps=52
M1003 a_64_49# a_33_9# vdd w_3_39# CMOSP w=40 l=2
+  ad=200 pd=90 as=0 ps=0
M1004 a_16_9# clk a_16_49# w_3_39# CMOSP w=40 l=2
+  ad=200 pd=90 as=240 ps=92
M1005 vdd clk a_33_9# w_3_39# CMOSP w=40 l=2
+  ad=0 pd=0 as=200 ps=90
M1006 a_64_9# a_33_9# gnd Gnd CMOSN w=20 l=2
+  ad=120 pd=52 as=0 ps=0
M1007 a_16_9# in gnd Gnd CMOSN w=20 l=2
+  ad=100 pd=50 as=0 ps=0
M1008 a_16_49# in vdd w_3_39# CMOSP w=40 l=2
+  ad=0 pd=0 as=0 ps=0
M1009 a_40_9# a_16_9# a_33_9# Gnd CMOSN w=20 l=2
+  ad=0 pd=0 as=100 ps=50
M1010 a_64_49# clk a_64_9# Gnd CMOSN w=20 l=2
+  ad=100 pd=50 as=0 ps=0
C0 clk vdd 0.13fF
C1 a_33_9# w_3_39# 0.21fF
C2 a_16_9# w_3_39# 0.14fF
C3 a_33_9# a_16_9# 0.17fF
C4 in vdd 0.13fF
C5 clk w_3_39# 0.30fF
C6 a_33_9# clk 0.11fF
C7 gnd a_64_49# 0.09fF
C8 a_16_9# clk 0.05fF
C9 gnd out 0.24fF
C10 vdd a_64_49# 0.45fF
C11 in w_3_39# 0.12fF
C12 inverter_0/w_0_n60# vdd 0.14fF
C13 out vdd 0.45fF
C14 a_33_9# gnd 0.03fF
C15 vdd w_3_39# 0.39fF
C16 a_33_9# vdd 0.45fF
C17 gnd a_16_9# 0.24fF
C18 inverter_0/w_0_n60# a_64_49# 0.09fF
C19 out a_64_49# 0.05fF
C20 a_16_9# vdd 0.03fF
C21 in clk 0.12fF
C22 inverter_0/w_0_n60# out 0.08fF
C23 a_64_49# w_3_39# 0.08fF
C24 gnd clk 0.39fF
C25 gnd Gnd 0.53fF
C26 a_16_9# Gnd 0.20fF
C27 a_33_9# Gnd 0.18fF
C28 w_3_39# Gnd 4.34fF
C29 out Gnd 0.10fF
C30 a_64_49# Gnd 0.25fF
C31 inverter_0/w_0_n60# Gnd 1.51fF
