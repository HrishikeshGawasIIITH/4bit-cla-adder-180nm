.include TSMC_180nm.txt

.param LAMBDA=0.09u
.param W=20*LAMBDA
.param width_N=W
.param width_P=2*W
.global gnd vdd

Vdd vdd gnd 1.8
Vdd2 vdd2 gnd 1.8
Vdd3 vdd3 gnd 1.8
Vdd4 vdd4 gnd 1.8
Vdd5 vdd5 gnd 1.8
Vdd6 vdd6 gnd 1.8
Vdd7 vdd7 gnd 1.8
Vdd_load vdd_load gnd 1.8

Vin_a0 a0_unsync gnd PULSE(1.8 0 0.3ns 50ps 50ps 0.75ns 1.5ns 0)
Vin_a1 a1_unsync gnd PULSE(1.8 0 0.3ns 50ps 50ps 1.5ns 3ns 0)
Vin_a2 a2_unsync gnd PULSE(1.8 0 0.3ns 50ps 50ps 3ns 6ns 0)
Vin_a3 a3_unsync gnd PULSE(1.8 0 0.3ns 50ps 50ps 6ns 12ns 0)

Vin_b0 b0_unsync gnd PULSE(1.8 0 0.3ns 50ps 50ps 12ns 24ns 0)
Vin_b1 b1_unsync gnd PULSE(1.8 0 0.3ns 50ps 50ps 24ns 48ns 0)
Vin_b2 b2_unsync gnd PULSE(1.8 0 0.3ns 50ps 50ps 48ns 96ns 0)
Vin_b3 b3_unsync gnd PULSE(1.8 0 0.3ns 50ps 50ps 96ns 192ns 0)
*change to 0.8ns
Vin_clk clk gnd PULSE(1.8 0 0 50ps 50ps 0.375ns 0.75ns 0)

.subckt inv in out vdd_inv gnd S=1
.param Wp = {2*W}
.param Wn = {W}

M5 out in vdd_inv vdd_inv CMOSP W={S*Wp} L={2*LAMBDA}
+AS={S*5*Wp*LAMBDA} PS={10*LAMBDA+S*2*Wp}
+AD={S*5*Wp*LAMBDA} PD={10*LAMBDA+S*2*Wp}
M6 out in gnd gnd CMOSN W={S*Wn} L={2*LAMBDA}
+AS={S*5*Wn*LAMBDA} PS={10*LAMBDA+S*2*Wn}
+AD={S*5*Wn*LAMBDA} PD={10*LAMBDA+S*2*Wn}
.ends inv

.subckt g_calc ai bi gi vdd_and gnd S=1
.param Wp = {2*W}
.param Wn = {2*W}

M1 gibar bi vdd_and vdd_and CMOSP W={S*Wp} L={2*LAMBDA}
+AS={S*5*Wp*LAMBDA} PS={10*LAMBDA+S*2*Wp}
+AD={S*5*Wp*LAMBDA} PD={10*LAMBDA+S*2*Wp}
M2 gibar ai vdd_and vdd_and CMOSP W={S*Wp} L={2*LAMBDA}
+AS={S*5*Wp*LAMBDA} PS={10*LAMBDA+S*2*Wp}
+AD={S*5*Wp*LAMBDA} PD={10*LAMBDA+S*2*Wp}

M3 gibar bi gi_temp gnd CMOSN W={S*Wn} L={2*LAMBDA}
+AS={S*5*Wn*LAMBDA} PS={10*LAMBDA+S*2*Wn}
+AD={S*5*Wn*LAMBDA} PD={10*LAMBDA+S*2*Wn}
M4 gi_temp ai gnd gnd CMOSN W={S*Wn} L={2*LAMBDA}
+AS={S*5*Wn*LAMBDA} PS={10*LAMBDA+S*2*Wn}
+AD={S*5*Wn*LAMBDA} PD={10*LAMBDA+S*2*Wn}

x1 gibar gi vdd_and gnd inv S=2
.ends g_calc

.subckt pi_calc ai bi pi vdd_xor gnd S=1
.param Wp = {2*W}
.param Wn = {1*W}

M7 pi_temp_1 ai vdd_xor vdd_xor CMOSP W={S*Wp} L={2*LAMBDA}
+AS={S*5*Wp*LAMBDA} PS={10*LAMBDA+S*2*Wp}
+AD={S*5*Wp*LAMBDA} PD={10*LAMBDA+S*2*Wp}
M8 pi bi_bar pi_temp_1 vdd_xor CMOSP W={S*Wp} L={2*LAMBDA}
+AS={S*5*Wp*LAMBDA} PS={10*LAMBDA+S*2*Wp}
+AD={S*5*Wp*LAMBDA} PD={10*LAMBDA+S*2*Wp}
M9 pi_temp_2 bi vdd_xor vdd_xor CMOSP W={S*Wp} L={2*LAMBDA}
+AS={S*5*Wp*LAMBDA} PS={10*LAMBDA+S*2*Wp}
+AD={S*5*Wp*LAMBDA} PD={10*LAMBDA+S*2*Wp}
M10 pi ai_bar pi_temp_2 vdd_xor CMOSP W={S*Wp} L={2*LAMBDA}
+AS={S*5*Wp*LAMBDA} PS={10*LAMBDA+S*2*Wp}
+AD={S*5*Wp*LAMBDA} PD={10*LAMBDA+S*2*Wp}

M11 pi_temp_3 ai_bar gnd gnd CMOSN W={S*width_N} L={2*LAMBDA}
+AS={S*5*width_N*LAMBDA} PS={10*LAMBDA+S*2*width_N}
+AD={S*5*width_N*LAMBDA} PD={10*LAMBDA+S*2*width_N}
M12 pi bi_bar pi_temp_3 gnd CMOSN W={S*width_N} L={2*LAMBDA}
+AS={S*5*width_N*LAMBDA} PS={10*LAMBDA+S*2*width_N}
+AD={S*5*width_N*LAMBDA} PD={10*LAMBDA+S*2*width_N}
M13 pi_temp_4 ai gnd gnd CMOSN W={S*width_N} L={2*LAMBDA}
+AS={S*5*width_N*LAMBDA} PS={10*LAMBDA+S*2*width_N}
+AD={S*5*width_N*LAMBDA} PD={10*LAMBDA+S*2*width_N}
M14 pi bi pi_temp_4 gnd CMOSN W={S*width_N} L={2*LAMBDA}
+AS={S*5*width_N*LAMBDA} PS={10*LAMBDA+S*2*width_N}
+AD={S*5*width_N*LAMBDA} PD={10*LAMBDA+S*2*width_N}

x1 ai ai_bar vdd_xor gnd inv
x2 bi bi_bar vdd_xor gnd inv
.ends pi_calc

.subckt c2_calc p1 g0 g1 c2 vdd_c2 gnd S=1
.param Wp = {2*W}
.param Wn = {1*W}

M19 c2_temp_1 g0 vdd_c2 vdd_c2 CMOSP W={S*Wp} L={2*LAMBDA}
+AS={S*5*Wp*LAMBDA} PS={10*LAMBDA+S*2*Wp}
+AD={S*5*Wp*LAMBDA} PD={10*LAMBDA+S*2*Wp}
M20 c2_bar g1 c2_temp_1 vdd_c2 CMOSP W={S*Wp} L={2*LAMBDA}
+AS={S*5*Wp*LAMBDA} PS={10*LAMBDA+S*2*Wp}
+AD={S*5*Wp*LAMBDA} PD={10*LAMBDA+S*2*Wp}
M21 c2_temp_1 p1 vdd_c2 vdd_c2 CMOSP W={S*Wp} L={2*LAMBDA}
+AS={S*5*Wp*LAMBDA} PS={10*LAMBDA+S*2*Wp}
+AD={S*5*Wp*LAMBDA} PD={10*LAMBDA+S*2*Wp}

M22 c2_bar p1 c2_temp_2 gnd CMOSN W={2*S*Wn} L={2*LAMBDA}
+AS={2*S*5*Wn*LAMBDA} PS={10*LAMBDA+2*S*2*Wn}
+AD={2*S*5*Wn*LAMBDA} PD={10*LAMBDA+2*S*2*Wn}
M23 c2_temp_2 g0 gnd gnd CMOSN W={2*S*Wn} L={2*LAMBDA}
+AS={2*S*5*Wn*LAMBDA} PS={10*LAMBDA+2*S*2*Wn}
+AD={2*S*5*Wn*LAMBDA} PD={10*LAMBDA+2*S*2*Wn}
M24 c2_bar g1 gnd gnd CMOSN W={S*Wn} L={2*LAMBDA}
+AS={S*5*Wn*LAMBDA} PS={10*LAMBDA+S*2*Wn}
+AD={S*5*Wn*LAMBDA} PD={10*LAMBDA+S*2*Wn}

x1 c2_bar c2 vdd_c2 gnd inv
.ends c2_calc

.subckt c3_calc p1 p2 g0 g1 g2 c3 vdd_c3 gnd S=1
M27 c3_temp_1 g0 vdd_c3 vdd_c3 CMOSP W={S*width_P} L={2*LAMBDA}
+AS={S*5*width_P*LAMBDA} PS={10*LAMBDA+S*2*width_P}
+AD={S*5*width_P*LAMBDA} PD={10*LAMBDA+S*2*width_P}
M28 c3_temp_2 g1 c3_temp_1 vdd_c3 CMOSP W={S*width_P} L={2*LAMBDA}
+AS={S*5*width_P*LAMBDA} PS={10*LAMBDA+S*2*width_P}
+AD={S*5*width_P*LAMBDA} PD={10*LAMBDA+S*2*width_P}
M29 c3_bar g2 c3_temp_2 vdd_c3 CMOSP W={S*width_P} L={2*LAMBDA}
+AS={S*5*width_P*LAMBDA} PS={10*LAMBDA+S*2*width_P}
+AD={S*5*width_P*LAMBDA} PD={10*LAMBDA+S*2*width_P}
M30 c3_temp_1 p1 vdd_c3 vdd_c3 CMOSP W={S*width_P} L={2*LAMBDA}
+AS={S*5*width_P*LAMBDA} PS={10*LAMBDA+S*2*width_P}
+AD={S*5*width_P*LAMBDA} PD={10*LAMBDA+S*2*width_P}
M31 c3_temp_2 p2 vdd_c3 vdd_c3 CMOSP W={S*width_P} L={2*LAMBDA}
+AS={S*5*width_P*LAMBDA} PS={10*LAMBDA+S*2*width_P}
+AD={S*5*width_P*LAMBDA} PD={10*LAMBDA+S*2*width_P}

M32 c3_bar p2 c3_temp_3 gnd CMOSN W={S*width_N} L={2*LAMBDA}
+AS={S*5*width_N*LAMBDA} PS={10*LAMBDA+S*2*width_N}
+AD={S*5*width_N*LAMBDA} PD={10*LAMBDA+S*2*width_N}
M33 c3_temp_3 p1 c3_temp_4 gnd CMOSN W={S*width_N} L={2*LAMBDA}
+AS={S*5*width_N*LAMBDA} PS={10*LAMBDA+S*2*width_N}
+AD={S*5*width_N*LAMBDA} PD={10*LAMBDA+S*2*width_N}
M34 c3_temp_4 g0 gnd gnd CMOSN W={S*width_N} L={2*LAMBDA}
+AS={S*5*width_N*LAMBDA} PS={10*LAMBDA+S*2*width_N}
+AD={S*5*width_N*LAMBDA} PD={10*LAMBDA+S*2*width_N}
M35 c3_temp_3 g1 gnd gnd CMOSN W={S*width_N} L={2*LAMBDA}
+AS={S*5*width_N*LAMBDA} PS={10*LAMBDA+S*2*width_N}
+AD={S*5*width_N*LAMBDA} PD={10*LAMBDA+S*2*width_N}
M36 c3_bar g2 gnd gnd CMOSN W={S*width_N} L={2*LAMBDA}
+AS={S*5*width_N*LAMBDA} PS={10*LAMBDA+S*2*width_N}
+AD={S*5*width_N*LAMBDA} PD={10*LAMBDA+S*2*width_N}

x1 c3_bar c3 vdd_c3 gnd inv
.ends c3_calc

.subckt c4_calc p1 p2 p3 g0 g1 g2 g3 c4 vdd_c4 gnd S=1
M39 c4_temp_1 g0 vdd_c4 vdd_c4 CMOSP W={S*width_P} L={2*LAMBDA}
+AS={S*5*width_P*LAMBDA} PS={10*LAMBDA+S*2*width_P}
+AD={S*5*width_P*LAMBDA} PD={10*LAMBDA+S*2*width_P}
M40 c4_temp_2 g1 c4_temp_1 vdd_c4 CMOSP W={S*width_P} L={2*LAMBDA}
+AS={S*5*width_P*LAMBDA} PS={10*LAMBDA+S*2*width_P}
+AD={S*5*width_P*LAMBDA} PD={10*LAMBDA+S*2*width_P}
M41 c4_temp_3 g2 c4_temp_2 vdd_c4 CMOSP W={S*width_P} L={2*LAMBDA}
+AS={S*5*width_P*LAMBDA} PS={10*LAMBDA+S*2*width_P}
+AD={S*5*width_P*LAMBDA} PD={10*LAMBDA+S*2*width_P}
M42 c4_bar g3 c4_temp_3 vdd_c4 CMOSP W={S*width_P} L={2*LAMBDA}
+AS={S*5*width_P*LAMBDA} PS={10*LAMBDA+S*2*width_P}
+AD={S*5*width_P*LAMBDA} PD={10*LAMBDA+S*2*width_P}
M43 c4_temp_1 p1 vdd_c4 vdd_c4 CMOSP W={S*width_P} L={2*LAMBDA}
+AS={S*5*width_P*LAMBDA} PS={10*LAMBDA+S*2*width_P}
+AD={S*5*width_P*LAMBDA} PD={10*LAMBDA+S*2*width_P}
M44 c4_temp_2 p2 vdd_c4 vdd_c4 CMOSP W={S*width_P} L={2*LAMBDA}
+AS={S*5*width_P*LAMBDA} PS={10*LAMBDA+S*2*width_P}
+AD={S*5*width_P*LAMBDA} PD={10*LAMBDA+S*2*width_P}
M45 c4_temp_3 p3 vdd_c4 vdd_c4 CMOSP W={S*width_P} L={2*LAMBDA}
+AS={S*5*width_P*LAMBDA} PS={10*LAMBDA+S*2*width_P}
+AD={S*5*width_P*LAMBDA} PD={10*LAMBDA+S*2*width_P}

M46 c4_bar p3 c4_temp_4 gnd CMOSN W={S*width_N} L={2*LAMBDA}
+AS={S*5*width_N*LAMBDA} PS={10*LAMBDA+S*2*width_N}
+AD={S*5*width_N*LAMBDA} PD={10*LAMBDA+S*2*width_N}
M47 c4_temp_4 p2 c4_temp_5 gnd CMOSN W={S*width_N} L={2*LAMBDA}
+AS={S*5*width_N*LAMBDA} PS={10*LAMBDA+S*2*width_N}
+AD={S*5*width_N*LAMBDA} PD={10*LAMBDA+S*2*width_N}
M48 c4_temp_5 p1 c4_temp_6 gnd CMOSN W={S*width_N} L={2*LAMBDA}
+AS={S*5*width_N*LAMBDA} PS={10*LAMBDA+S*2*width_N}
+AD={S*5*width_N*LAMBDA} PD={10*LAMBDA+S*2*width_N}
M49 c4_temp_6 g0 gnd gnd CMOSN W={S*width_N} L={2*LAMBDA}
+AS={S*5*width_N*LAMBDA} PS={10*LAMBDA+S*2*width_N}
+AD={S*5*width_N*LAMBDA} PD={10*LAMBDA+S*2*width_N}
M50 c4_temp_5 g1 gnd gnd CMOSN W={S*width_N} L={2*LAMBDA}
+AS={S*5*width_N*LAMBDA} PS={10*LAMBDA+S*2*width_N}
+AD={S*5*width_N*LAMBDA} PD={10*LAMBDA+S*2*width_N}
M51 c4_temp_4 g2 gnd gnd CMOSN W={S*width_N} L={2*LAMBDA}
+AS={S*5*width_N*LAMBDA} PS={10*LAMBDA+S*2*width_N}
+AD={S*5*width_N*LAMBDA} PD={10*LAMBDA+S*2*width_N}
M52 c4_bar g3 gnd gnd CMOSN W={S*width_N} L={2*LAMBDA}
+AS={S*5*width_N*LAMBDA} PS={10*LAMBDA+S*2*width_N}
+AD={S*5*width_N*LAMBDA} PD={10*LAMBDA+S*2*width_N}

x1 c4_bar c4 vdd_c4 gnd inv
.ends c4_calc

.subckt dff in out clk vdd gnd S=1
M1 temp1 in vdd vdd CMOSP W={S*width_P} L={2*LAMBDA}
+AS={S*5*width_P*LAMBDA} PS={10*LAMBDA+S*2*width_P}
+AD={S*5*width_P*LAMBDA} PD={10*LAMBDA+S*2*width_P}
M2 temp2 clk temp1 vdd CMOSP W={S*width_P} L={2*LAMBDA}
+AS={S*5*width_P*LAMBDA} PS={10*LAMBDA+S*2*width_P}
+AD={S*5*width_P*LAMBDA} PD={10*LAMBDA+S*2*width_P}
M3 temp2 in gnd gnd CMOSN W={S*width_N} L={2*LAMBDA}
+AS={S*5*width_N*LAMBDA} PS={10*LAMBDA+S*2*width_N}
+AD={S*5*width_N*LAMBDA} PD={10*LAMBDA+S*2*width_N}

M4 temp3 clk vdd vdd CMOSP W={S*width_P} L={2*LAMBDA}
+AS={S*5*width_P*LAMBDA} PS={10*LAMBDA+S*2*width_P}
+AD={S*5*width_P*LAMBDA} PD={10*LAMBDA+S*2*width_P}
M5 temp3 temp2 temp4 gnd CMOSN W={S*width_N} L={2*LAMBDA}
+AS={S*5*width_N*LAMBDA} PS={10*LAMBDA+S*2*width_N}
+AD={S*5*width_N*LAMBDA} PD={10*LAMBDA+S*2*width_N}
M6 temp4 clk gnd gnd CMOSN W={S*width_N} L={2*LAMBDA}
+AS={S*5*width_N*LAMBDA} PS={10*LAMBDA+S*2*width_N}
+AD={S*5*width_N*LAMBDA} PD={10*LAMBDA+S*2*width_N}

M7 out_bar temp3 vdd vdd CMOSP W={S*width_P} L={2*LAMBDA}
+AS={S*5*width_P*LAMBDA} PS={10*LAMBDA+S*2*width_P}
+AD={S*5*width_P*LAMBDA} PD={10*LAMBDA+S*2*width_P}
M8 out_bar clk temp5 gnd CMOSN W={S*width_N} L={2*LAMBDA}
+AS={S*5*width_N*LAMBDA} PS={10*LAMBDA+S*2*width_N}
+AD={S*5*width_N*LAMBDA} PD={10*LAMBDA+S*2*width_N}
M9 temp5 temp3 gnd gnd CMOSN W={S*width_N} L={2*LAMBDA}
+AS={S*5*width_N*LAMBDA} PS={10*LAMBDA+S*2*width_N}
+AD={S*5*width_N*LAMBDA} PD={10*LAMBDA+S*2*width_N}

x1 out_bar out vdd gnd inv
.ends dff

x1 a0 b0 p0 vdd3 gnd pi_calc
x2 a1 b1 p1 vdd gnd pi_calc
x3 a2 b2 p2 vdd gnd pi_calc
x4 a3 b3 p3 vdd gnd pi_calc

x5 a0 b0 g0 vdd4 gnd g_calc
x6 a1 b1 g1 vdd gnd g_calc
x7 a2 b2 g2 vdd gnd g_calc
x8 a3 b3 g3 vdd gnd g_calc

x10 p1 g0 g1 c2 vdd5 gnd c2_calc
x11 p1 p2 g0 g1 g2 c3 vdd6 gnd c3_calc
x12 p1 p2 p3 g0 g1 g2 g3 c4 vdd7 gnd c4_calc

R1 p0 s0 0
x13 g0 p1 s1 vdd gnd pi_calc
x14 c2 p2 s2 vdd gnd pi_calc
x15 c3 p3 s3 vdd gnd pi_calc

x16 a0_unsync a0 clk vdd gnd dff
x17 a1_unsync a1 clk vdd gnd dff
x18 a2_unsync a2 clk vdd gnd dff
x19 a3_unsync a3 clk vdd gnd dff

x20 b0_unsync b0 clk vdd gnd dff
x21 b1_unsync b1 clk vdd gnd dff
x22 b2_unsync b2 clk vdd gnd dff
x23 b3_unsync b3 clk vdd gnd dff

x24 s0 s0_sync clk vdd gnd dff
x25 s1 s1_sync clk vdd gnd dff
x26 s2 s2_sync clk vdd gnd dff
x27 s3 s3_sync clk vdd gnd dff

x28 c4 c4_sync clk vdd gnd dff

x29 s0_sync nc1 vdd_load gnd inv
x30 s1_sync nc2 vdd_load gnd inv
x31 s2_sync nc3 vdd_load gnd inv
x32 s3_sync nc4 vdd_load gnd inv

x33 c4_sync nc5 vdd_load gnd inv

x34 a0 inv_test vdd2 gnd inv
x35 inv_test inv_test_load vdd_load gnd inv

*193 ns
.tran 1ps 193ns

.measure tran tplh_xor
+TRIG v(a0) VAL=0.9 RISE=1
+TARG v(p0) VAL=0.9 RISE=1
.measure tran tphl_xor
+TRIG v(a0) VAL=0.9 FALL=1
+TARG v(p0) VAL=0.9 FALL=1
.measure tran tp_xor param = (tplh_xor + tphl_xor)/2

.measure tran rms_curr_xor RMS i(vdd3)
.measure tran rms_power_xor param = (rms_curr_xor*1.8)

.measure tran tplh_and
+TRIG v(a0) VAL=0.9 RISE=9
+TARG v(g0) VAL=0.9 RISE=1
.measure tran tphl_and
+TRIG v(a0) VAL=0.9 FALL=9
+TARG v(g0) VAL=0.9 FALL=1
.measure tran tp_and param = (tplh_and + tphl_and)/2

.measure tran rms_curr_and RMS i(vdd4)
.measure tran rms_power_and param = (rms_curr_and*1.8)

.measure tran tplh_inv
+TRIG v(a0) VAL=0.9 FALL=1
+TARG v(inv_test) VAL=0.9 RISE=1
.measure tran tphl_inv
+TRIG v(a0) VAL=0.9 RISE=1
+TARG v(inv_test) VAL=0.9 FALL=1
.measure tran tp_inv param = (tplh_inv + tphl_inv)/2

.measure tran rms_curr_inv RMS i(vdd2)
.measure tran rms_power_inv param = (rms_curr_inv*1.8)

.measure tran rms_curr_c2 RMS i(vdd5)
.measure tran rms_power_c2 param = (rms_curr_c2*1.8)

.measure tran rms_curr_c3 RMS i(vdd6)
.measure tran rms_power_c3 param = (rms_curr_c3*1.8)

.measure tran rms_curr_c4 RMS i(vdd7)
.measure tran rms_power_c4 param = (rms_curr_c4*1.8)

.measure tran rms_curr RMS i(vdd)
.measure tran rms_power param = (rms_curr*1.8)

.control
run
set curplottitle="Hrishikesh-2024122006-q3-input"
*plot v(a0_unsync) 2+v(a1_unsync) 4+v(a2_unsync) 6+v(a3_unsync) 8+v(b0_unsync) 10+v(b1_unsync) 12+v(b2_unsync) 14+v(b3_unsync) 16+v(clk)
set curplottitle="Hrishikesh-2024122006-q3-input_sync"
*plot v(a0) 2+v(a1) 4+v(a2) 6+v(a3) 8+v(b0) 10+v(b1) 12+v(b2) 14+v(b3) 16+v(clk)
set curplottitle="Hrishikesh-2024122006-q3-output"
*plot v(s0) 2+v(s1) 4+v(s2) 6+v(s3) 8+v(c4) 10+v(clk)
set curplottitle="Hrishikesh-2024122006-q3-output_sync"
*plot v(s0_sync) 2+v(s1_sync) 4+v(s2_sync) 6+v(s3_sync) 8+v(c4_sync) 10+v(clk)

set curplottitle="Hrishikesh-2024122006-q3-xor"
*plot v(a0) 2+v(b0) 4+v(p0) xlimit 0n 10n
set curplottitle="Hrishikesh-2024122006-q3-inv"
*plot v(a0) 2+v(inv_test) xlimit 0n 5n
set curplottitle="Hrishikesh-2024122006-q3-and/c1"
*plot v(a0) 2+v(b0) 4+v(g0) xlimit 10n 50n
set curplottitle="Hrishikesh-2024122006-q3-c2"
*plot v(g1) 2+v(p1) 4+v(g0) 6+v(c2) xlimit 10n 50n
set curplottitle="Hrishikesh-2024122006-q3-c3"
*plot v(g2) 2+v(p2) 4+v(g1) 6+v(p1) 8+v(g0) 10+v(c3) xlimit 15n 100n
set curplottitle="Hrishikesh-2024122006-q3-c4"
*plot v(g3) 2+v(p3) 4+v(g2) 6+v(p2) 8+v(g1) 10+v(p1) 12+v(g0) 14+v(c3) 16+v(c4)

let power = abs(i(vdd))*1.8
set curplottitle="Hrishikesh-2024122006-q3-power"
*plot power
set hcopypscolor = 1

*hardcopy q4.eps
.endc
